Hardware enable unplugged, protected battery 5.4 V
Vbat pfet 0 5.4
R31 pfet sw_on 10k
R32 enable 0 100k
* Unplugged: no throw connected
.control
op
print v(enable) i(Vbat)
.endc
.end

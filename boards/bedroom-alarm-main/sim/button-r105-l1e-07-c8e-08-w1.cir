Remote button sensitivity: series=105 ohm, L=1e-07, C=8e-08, Rwire=1.0
VDD supply 0 3.3
Rpull supply gpio 10000
Cdeb gpio 0 8e-08
Rseries gpio cable 105
Lwire cable remote 1e-07
Rwire remote contact 1.0
Vcontact control 0 PULSE(0 3.3 1m 1n 1n 1m 5m)
Sbutton contact 0 control 0 BUTTON
.model BUTTON SW(Ron=0.05 Roff=1e12 Vt=1.65 Vh=0)
.tran 50n 4m
.meas tran gpio_min_c18 MIN v(gpio) FROM=0.99m TO=2m
.meas tran gpio_max_c18 MAX v(gpio) FROM=0.99m TO=4m
.meas tran press_current_c18 MAX i(Lwire) FROM=1m TO=1.1m
.meas tran held_c18 FIND v(gpio) AT=1.9m
.meas tran released_c18 FIND v(gpio) AT=3.9m
.end
